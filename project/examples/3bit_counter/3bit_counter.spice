** sch_path: /home/ethan/GitHub/sky130_schematics/examples/3bit_counter/3bit_counter.sch
.subckt 3bit_counter VGND VNB VPB VPWR
*.PININFO VGND:I VNB:I VPB:I VPWR:I
x1 CLK net1 VGND VNB VPB VPWR net6 sky130_fd_sc_hd__dfxtp_1
x2 CLK net5 VGND VNB VPB VPWR net7 sky130_fd_sc_hd__dfxtp_1
x4 net6 net2 VGND VNB VPB VPWR net9 net1 sky130_fd_sc_hd__ha_1
x5 net7 net3 VGND VNB VPB VPWR net2 net5 sky130_fd_sc_hd__ha_1
x3 CLK net4 VGND VNB VPB VPWR net8 sky130_fd_sc_hd__dfxtp_1
x6 net8 VPWR VGND VNB VPB VPWR net3 net4 sky130_fd_sc_hd__ha_1
.ends
.end
